** Profile: "stab2Prot2-DCsweep1"  [ C:\Users\mvman\projects2\OrCAD\AnaSim\stabilizTensiune\stab_v1-stab2Prot2-DCsweep1.sim ]

** Creating circuit file "stab_v1-stab2Prot2-DCsweep1.sim.cir"
** WARNING: THIS AUTOMATICALLY GENERATED FILE MAY BE OVERWRITTEN BY SUBSEQUENT SIMULATIONS

*Libraries:
* Local Libraries :
* From [PSPICE NETLIST] section of C:\Orcad\PSpice\PSpice.ini file:
.lib "nom.lib"

*Analysis directives:
.DC LIN V_V1 10 15 0.5
.PROBE V(*) I(*) W(*) D(*) NOISE(*)
.INC ".\stab_v1-stab2Prot2.net"

.END
